.circuit
V1 1 GND dc 10
V2 2 GND dc 5
V3 3 GND dc 12
V4 4 GND dc 7

I1 1 5 dc 3
I2 2 6 dc 2
I3 3 7 dc 1.5
I4 4 8 dc 4

R1 1 2 100
R2 2 3 200
R3 3 4 300
R4 4 5 400
R5 5 6 500
R6 6 7 600
R7 7 8 700
R8 8 1 800
R9 2 7 1000
R10 3 8 1500
R11 5 7 2000
R12 6 8 2500

.end
