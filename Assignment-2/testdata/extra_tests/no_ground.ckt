.circuit
V1 1 2 dc 5
R1 2 3 1
R2 3 1 1
.end
# There is no ground in this circuit
